# Ansys Electronics Desktop project, version 2025.1
materials:
  vacuum: permittivity=1
  silicon: permittivity=11.9
  pec: conductivity=1e+30

design Qbit_hfss (HFSS, Eigenmode, model units mm)
variables:
  Lj = 11nH
  Cj = 0fF
geometry:
  readout_wire_Q1_path = polyline(z=0, xy: (0.0002125, 0.00013) (0.0002375, 0.00013) (0.00032, 0.000195) (0.000425, 0.000195))
  readout_wire_Q1 = polyline((0.0002125, 0.000135, 0) (0.0002125, 0.000125, 0))
  readout_wire_Q1.sweep_along_path(readout_wire_Q1_path)
  readout_wire_sub_Q1_path = polyline(z=0, xy: (0.0002125, 0.00013) (0.0002375, 0.00013) (0.00032, 0.000195) (0.000425, 0.000195))
  readout_wire_sub_Q1 = polyline((0.0002125, 0.000141, 0) (0.0002125, 0.000119, 0))
  readout_wire_sub_Q1.sweep_along_path(readout_wire_sub_Q1_path)
  pad_top_Q1 = rectangle(corner=(-0.0002125, 1.5e-05, 0), x_size=0.000425, y_size=9e-05)
  pad_bot_Q1 = rectangle(corner=(-0.0002125, -0.000105, 0), x_size=0.000425, y_size=9e-05)
  rect_pk_Q1 = rectangle(corner=(-0.000325, -0.000325, 0), x_size=0.00065, y_size=0.00065)
  readout_connector_pad_Q1 = rectangle(corner=(1.25e-05, 0.00012, 0), x_size=0.0002, y_size=3e-05)
  JJ_rect_Lj_Q1_rect_jj = rectangle(corner=(-1e-05, -1.5e-05, 0), x_size=2e-05, y_size=3e-05)
  JJ_Lj_Q1_rect_jj_ = polyline((0, -1.5e-05, 0) (0, 1.5e-05, 0))
  ground_main_plane = rectangle(corner=(-0.001, -0.001, 0), x_size=0.002, y_size=0.002)
  main [silicon] = box(corner=(-0.001, -0.001, -0.00075), size=(0.002, 0.002, 0.00075))
  sample_holder [vacuum] = box(corner=(-0.001, -0.001, -0.00165), size=(0.002, 0.002, 0.00254))
  ground_main_plane.subtract(rect_pk_Q1, readout_wire_sub_Q1)
boundaries and excitations:
  Lj_Lj_Q1_rect_jj: Lumped RLC Objects=JJ_rect_Lj_Q1_rect_jj CurrentLine{(0, -0.015, 0) -> (0, 0.015, 0)} RLC_Type=Parallel Inductance=10nH
  PerfE: Perfect E Objects=[readout_wire_Q1, pad_top_Q1, pad_bot_Q1, readout_connector_pad_Q1, ground_main_plane]
mesh:
  small_mesh: LengthBased Objects=JJ_rect_Lj_Q1_rect_jj MaxLength=7um
setups:
  Setup: HfssEigen MinimumFrequency=4GHz NumModes=1 MaxDeltaFreq=0.4 ConvergeOnRealFreq=true MaximumPasses=6 MinimumPasses=1 MinimumConvergedPasses=1 PercentRefinement=30 BasisOrder=1
source amplitudes:
  #-10:1: 1 0
reports:
  Freq. vs. pass: re(Mode(1)) vs Pass on Setup : AdaptivePass [Cj=0fF Lj=11nH]

design Readout_hfss (HFSS, Eigenmode, model units mm)
variables:
  Lj = 10nH
  Cj = 0fF
geometry:
  trace_readout_path = polyline(z=0, xy: (0.000425, 0.000195) (0.000525, 0.000195) (0.000525, 0.000689354) (0.000725, 0.000689354) (0.000725, -0.000299354) (0.000925, -0.000299354) (0.000925, 0.000689354) (0.001125, 0.000689354) (0.001125, -0.000299354) (0.001325, -0.000299354) (0.001325, 0.000689354) (0.001525, 0.000689354) (0.001525, 0) (0.00175, 0))
  trace_readout_path.fillet(Vertices=trace_readout_path.vertex(at (1.525, 0, 0), at (1.525, 0.689354, 0), at (1.325, 0.689354, 0), at (1.325, -0.299354, 0), at (1.125, -0.299354, 0), at (1.125, 0.689354, 0), at (0.925, 0.689354, 0), at (0.925, -0.299354, 0), at (0.725, -0.299354, 0), at (0.725, 0.689354, 0), at (0.525, 0.689354, 0), at (0.525, 0.195, 0)) Radius=9e-05 Setback=0mm)
  trace_readout = polyline((0.000425, 0.0002, 0) (0.000425, 0.00019, 0))
  trace_readout.sweep_along_path(trace_readout_path)
  cut_readout_path = polyline(z=0, xy: (0.000425, 0.000195) (0.000525, 0.000195) (0.000525, 0.000689354) (0.000725, 0.000689354) (0.000725, -0.000299354) (0.000925, -0.000299354) (0.000925, 0.000689354) (0.001125, 0.000689354) (0.001125, -0.000299354) (0.001325, -0.000299354) (0.001325, 0.000689354) (0.001525, 0.000689354) (0.001525, 0) (0.00175, 0))
  cut_readout_path.fillet(Vertices=cut_readout_path.vertex(at (1.525, 0, 0), at (1.525, 0.689354, 0), at (1.325, 0.689354, 0), at (1.325, -0.299354, 0), at (1.125, -0.299354, 0), at (1.125, 0.689354, 0), at (0.925, 0.689354, 0), at (0.925, -0.299354, 0), at (0.725, -0.299354, 0), at (0.725, 0.689354, 0), at (0.525, 0.689354, 0), at (0.525, 0.195, 0)) Radius=9e-05 Setback=0mm)
  cut_readout = polyline((0.000425, 0.000206, 0) (0.000425, 0.000184, 0))
  cut_readout.sweep_along_path(cut_readout_path)
  g_wb [pec] = bondwire(WireType=LOW WireDiameter=0.015mm NumSides=6 XPadPos=0.00058 YPadPos=0.000442177 ZPadPos=0 XDir=-1 YDir=0 ZDir=0 Distance=0.00011 h1=0.00011 h2=0mm alpha=80deg beta=80deg WhichAxis=Z)
  g_wb_1 [pec] = bondwire(WireType=LOW WireDiameter=0.015mm NumSides=6 XPadPos=0.00067 YPadPos=0.00035978467 ZPadPos=0 XDir=1 YDir=0 ZDir=0 Distance=0.00011 h1=0.00011 h2=0mm alpha=80deg beta=80deg WhichAxis=Z)
  g_wb_2 [pec] = bondwire(WireType=LOW WireDiameter=0.015mm NumSides=6 XPadPos=0.00067 YPadPos=3.0215334e-05 ZPadPos=0 XDir=1 YDir=0 ZDir=0 Distance=0.00011 h1=0.00011 h2=0mm alpha=80deg beta=80deg WhichAxis=Z)
  g_wb_3 [pec] = bondwire(WireType=LOW WireDiameter=0.015mm NumSides=6 XPadPos=0.00098 YPadPos=3.0215334e-05 ZPadPos=0 XDir=-1 YDir=0 ZDir=0 Distance=0.00011 h1=0.00011 h2=0mm alpha=80deg beta=80deg WhichAxis=Z)
  g_wb_4 [pec] = bondwire(WireType=LOW WireDiameter=0.015mm NumSides=6 XPadPos=0.00098 YPadPos=0.00035978467 ZPadPos=0 XDir=-1 YDir=0 ZDir=0 Distance=0.00011 h1=0.00011 h2=0mm alpha=80deg beta=80deg WhichAxis=Z)
  g_wb_5 [pec] = bondwire(WireType=LOW WireDiameter=0.015mm NumSides=6 XPadPos=0.00107 YPadPos=0.00035978467 ZPadPos=0 XDir=1 YDir=0 ZDir=0 Distance=0.00011 h1=0.00011 h2=0mm alpha=80deg beta=80deg WhichAxis=Z)
  g_wb_6 [pec] = bondwire(WireType=LOW WireDiameter=0.015mm NumSides=6 XPadPos=0.00107 YPadPos=3.0215334e-05 ZPadPos=0 XDir=1 YDir=0 ZDir=0 Distance=0.00011 h1=0.00011 h2=0mm alpha=80deg beta=80deg WhichAxis=Z)
  g_wb_7 [pec] = bondwire(WireType=LOW WireDiameter=0.015mm NumSides=6 XPadPos=0.00138 YPadPos=3.0215334e-05 ZPadPos=0 XDir=-1 YDir=0 ZDir=0 Distance=0.00011 h1=0.00011 h2=0mm alpha=80deg beta=80deg WhichAxis=Z)
  g_wb_8 [pec] = bondwire(WireType=LOW WireDiameter=0.015mm NumSides=6 XPadPos=0.00138 YPadPos=0.00035978467 ZPadPos=0 XDir=-1 YDir=0 ZDir=0 Distance=0.00011 h1=0.00011 h2=0mm alpha=80deg beta=80deg WhichAxis=Z)
  g_wb_9 [pec] = bondwire(WireType=LOW WireDiameter=0.015mm NumSides=6 XPadPos=0.00147 YPadPos=0.000344677 ZPadPos=0 XDir=1 YDir=0 ZDir=0 Distance=0.00011 h1=0.00011 h2=0mm alpha=80deg beta=80deg WhichAxis=Z)
  open_to_ground_open_to_ground = rectangle(corner=(0.00175, -1.1e-05, 0), x_size=6e-06, y_size=2.2e-05)
  endcap_readout_start = rectangle(corner=(0.000419, 0.000184, 0), x_size=6e-06, y_size=2.2e-05)
  endcap_readout_end = rectangle(corner=(0.00175, -1.1e-05, 0), x_size=6e-06, y_size=2.2e-05)
  ground_main_plane = rectangle(corner=(0.000225, -0.000499354, 0), x_size=0.001731, y_size=0.001388708)
  main [silicon] = box(corner=(0.000225, -0.000499354, -0.00075), size=(0.001731, 0.001388708, 0.00075))
  sample_holder [vacuum] = box(corner=(0.000225, -0.000499354, -0.00165), size=(0.001731, 0.001388708, 0.00254))
  ground_main_plane.subtract(cut_readout, endcap_readout_end, open_to_ground_open_to_ground, endcap_readout_start)
boundaries and excitations:
  PerfE: Perfect E Objects=[trace_readout, ground_main_plane]
setups:
  Setup: HfssEigen MinimumFrequency=1GHz NumModes=1 MaxDeltaFreq=0.5 ConvergeOnRealFreq=true MaximumPasses=15 MinimumPasses=1 MinimumConvergedPasses=1 PercentRefinement=30 BasisOrder=1
source amplitudes:
  #-10:1: 1 0
field plots:
  Mag_E1, Mag_E1_2: E Field over main on Setup : LastAdaptive at Phase=0deg
reports:
  Freq. vs. pass: re(Mode(1)) vs Pass on Setup : AdaptivePass

design TransmonResonator_hfss (HFSS, Eigenmode, model units mm)
variables:
  Lj = 10nH
  Cj = 0fF
geometry:
  readout_wire_Q1_path = polyline(z=0, xy: (0.0002125, 0.00013) (0.0002375, 0.00013) (0.00032, 0.000195) (0.000425, 0.000195))
  readout_wire_Q1 = polyline((0.0002125, 0.000135, 0) (0.0002125, 0.000125, 0))
  readout_wire_Q1.sweep_along_path(readout_wire_Q1_path)
  readout_wire_sub_Q1_path = polyline(z=0, xy: (0.0002125, 0.00013) (0.0002375, 0.00013) (0.00032, 0.000195) (0.000425, 0.000195))
  readout_wire_sub_Q1 = polyline((0.0002125, 0.000141, 0) (0.0002125, 0.000119, 0))
  readout_wire_sub_Q1.sweep_along_path(readout_wire_sub_Q1_path)
  trace_readout_path = polyline(z=0, xy: (0.000425, 0.000195) (0.000525, 0.000195) (0.000525, 0.000689354) (0.000725, 0.000689354) (0.000725, -0.000299354) (0.000925, -0.000299354) (0.000925, 0.000689354) (0.001125, 0.000689354) (0.001125, -0.000299354) (0.001325, -0.000299354) (0.001325, 0.000689354) (0.001525, 0.000689354) (0.001525, 0) (0.00175, 0))
  trace_readout_path.fillet(Vertices=trace_readout_path.vertex(at (1.525, 0, 0), at (1.525, 0.689354, 0), at (1.325, 0.689354, 0), at (1.325, -0.299354, 0), at (1.125, -0.299354, 0), at (1.125, 0.689354, 0), at (0.925, 0.689354, 0), at (0.925, -0.299354, 0), at (0.725, -0.299354, 0), at (0.725, 0.689354, 0), at (0.525, 0.689354, 0), at (0.525, 0.195, 0)) Radius=9e-05 Setback=0mm)
  trace_readout = polyline((0.000425, 0.0002, 0) (0.000425, 0.00019, 0))
  trace_readout.sweep_along_path(trace_readout_path)
  cut_readout_path = polyline(z=0, xy: (0.000425, 0.000195) (0.000525, 0.000195) (0.000525, 0.000689354) (0.000725, 0.000689354) (0.000725, -0.000299354) (0.000925, -0.000299354) (0.000925, 0.000689354) (0.001125, 0.000689354) (0.001125, -0.000299354) (0.001325, -0.000299354) (0.001325, 0.000689354) (0.001525, 0.000689354) (0.001525, 0) (0.00175, 0))
  cut_readout_path.fillet(Vertices=cut_readout_path.vertex(at (1.525, 0, 0), at (1.525, 0.689354, 0), at (1.325, 0.689354, 0), at (1.325, -0.299354, 0), at (1.125, -0.299354, 0), at (1.125, 0.689354, 0), at (0.925, 0.689354, 0), at (0.925, -0.299354, 0), at (0.725, -0.299354, 0), at (0.725, 0.689354, 0), at (0.525, 0.689354, 0), at (0.525, 0.195, 0)) Radius=9e-05 Setback=0mm)
  cut_readout = polyline((0.000425, 0.000206, 0) (0.000425, 0.000184, 0))
  cut_readout.sweep_along_path(cut_readout_path)
  g_wb [pec] = bondwire(WireType=LOW WireDiameter=0.015mm NumSides=6 XPadPos=0.00058 YPadPos=0.000442177 ZPadPos=0 XDir=-1 YDir=0 ZDir=0 Distance=0.00011 h1=0.00011 h2=0mm alpha=80deg beta=80deg WhichAxis=Z)
  g_wb_1 [pec] = bondwire(WireType=LOW WireDiameter=0.015mm NumSides=6 XPadPos=0.00067 YPadPos=0.00035978467 ZPadPos=0 XDir=1 YDir=0 ZDir=0 Distance=0.00011 h1=0.00011 h2=0mm alpha=80deg beta=80deg WhichAxis=Z)
  g_wb_2 [pec] = bondwire(WireType=LOW WireDiameter=0.015mm NumSides=6 XPadPos=0.00067 YPadPos=3.0215334e-05 ZPadPos=0 XDir=1 YDir=0 ZDir=0 Distance=0.00011 h1=0.00011 h2=0mm alpha=80deg beta=80deg WhichAxis=Z)
  g_wb_3 [pec] = bondwire(WireType=LOW WireDiameter=0.015mm NumSides=6 XPadPos=0.00098 YPadPos=3.0215334e-05 ZPadPos=0 XDir=-1 YDir=0 ZDir=0 Distance=0.00011 h1=0.00011 h2=0mm alpha=80deg beta=80deg WhichAxis=Z)
  g_wb_4 [pec] = bondwire(WireType=LOW WireDiameter=0.015mm NumSides=6 XPadPos=0.00098 YPadPos=0.00035978467 ZPadPos=0 XDir=-1 YDir=0 ZDir=0 Distance=0.00011 h1=0.00011 h2=0mm alpha=80deg beta=80deg WhichAxis=Z)
  g_wb_5 [pec] = bondwire(WireType=LOW WireDiameter=0.015mm NumSides=6 XPadPos=0.00107 YPadPos=0.00035978467 ZPadPos=0 XDir=1 YDir=0 ZDir=0 Distance=0.00011 h1=0.00011 h2=0mm alpha=80deg beta=80deg WhichAxis=Z)
  g_wb_6 [pec] = bondwire(WireType=LOW WireDiameter=0.015mm NumSides=6 XPadPos=0.00107 YPadPos=3.0215334e-05 ZPadPos=0 XDir=1 YDir=0 ZDir=0 Distance=0.00011 h1=0.00011 h2=0mm alpha=80deg beta=80deg WhichAxis=Z)
  g_wb_7 [pec] = bondwire(WireType=LOW WireDiameter=0.015mm NumSides=6 XPadPos=0.00138 YPadPos=3.0215334e-05 ZPadPos=0 XDir=-1 YDir=0 ZDir=0 Distance=0.00011 h1=0.00011 h2=0mm alpha=80deg beta=80deg WhichAxis=Z)
  g_wb_8 [pec] = bondwire(WireType=LOW WireDiameter=0.015mm NumSides=6 XPadPos=0.00138 YPadPos=0.00035978467 ZPadPos=0 XDir=-1 YDir=0 ZDir=0 Distance=0.00011 h1=0.00011 h2=0mm alpha=80deg beta=80deg WhichAxis=Z)
  g_wb_9 [pec] = bondwire(WireType=LOW WireDiameter=0.015mm NumSides=6 XPadPos=0.00147 YPadPos=0.000344677 ZPadPos=0 XDir=1 YDir=0 ZDir=0 Distance=0.00011 h1=0.00011 h2=0mm alpha=80deg beta=80deg WhichAxis=Z)
  pad_top_Q1 = rectangle(corner=(-0.0002125, 1.5e-05, 0), x_size=0.000425, y_size=9e-05)
  pad_bot_Q1 = rectangle(corner=(-0.0002125, -0.000105, 0), x_size=0.000425, y_size=9e-05)
  rect_pk_Q1 = rectangle(corner=(-0.000325, -0.000325, 0), x_size=0.00065, y_size=0.00065)
  readout_connector_pad_Q1 = rectangle(corner=(1.25e-05, 0.00012, 0), x_size=0.0002, y_size=3e-05)
  open_to_ground_open_to_ground = rectangle(corner=(0.00175, -1.1e-05, 0), x_size=6e-06, y_size=2.2e-05)
  JJ_rect_Lj_Q1_rect_jj = rectangle(corner=(-1e-05, -1.5e-05, 0), x_size=2e-05, y_size=3e-05)
  JJ_Lj_Q1_rect_jj_ = polyline((0, -1.5e-05, 0) (0, 1.5e-05, 0))
  endcap_readout_end = rectangle(corner=(0.00175, -1.1e-05, 0), x_size=6e-06, y_size=2.2e-05)
  ground_main_plane = rectangle(corner=(-0.000525, -0.000525, 0), x_size=0.002481, y_size=0.001414354)
  main [silicon] = box(corner=(-0.000525, -0.000525, -0.00075), size=(0.002481, 0.001414354, 0.00075))
  sample_holder [vacuum] = box(corner=(-0.000525, -0.000525, -0.00165), size=(0.002481, 0.001414354, 0.00254))
  ground_main_plane.subtract(rect_pk_Q1, readout_wire_sub_Q1, endcap_readout_end, open_to_ground_open_to_ground, cut_readout)
boundaries and excitations:
  Lj_Lj_Q1_rect_jj: Lumped RLC Objects=JJ_rect_Lj_Q1_rect_jj CurrentLine{(0, -0.015, 0) -> (0, 0.015, 0)} RLC_Type=Parallel Inductance=10nH
  PerfE: Perfect E Objects=[readout_wire_Q1, trace_readout, pad_top_Q1, pad_bot_Q1, readout_connector_pad_Q1, ground_main_plane]
mesh:
  small_mesh: LengthBased Objects=JJ_rect_Lj_Q1_rect_jj MaxLength=7um
setups:
  Setup: HfssEigen MinimumFrequency=1GHz NumModes=2 MaxDeltaFreq=0.5 ConvergeOnRealFreq=true MaximumPasses=10 MinimumPasses=1 MinimumConvergedPasses=1 PercentRefinement=30 BasisOrder=1
source amplitudes:
  #-10:1: 0 0
  #-10:2: 1 0
field plots:
  Mag_E1: E Field over main on Setup : LastAdaptive at Phase=0deg
reports:
  Freq. vs. pass: re(Mode(1)), re(Mode(2)) vs Pass on Setup : AdaptivePass [Cj=0fF Lj=10nH]

design TwoTransmons_hfss (HFSS, Eigenmode, model units mm)
variables:
  Lj1 = 13nH
  Cj1 = 0fF
  Lj2 = 9nH
  Cj2 = 0fF
geometry:
  readout_wire_Q1_path = polyline(z=0, xy: (0.0002125, 0.00013) (0.0002375, 0.00013) (0.00032, 0.000195) (0.000425, 0.000195))
  readout_wire_Q1 = polyline((0.0002125, 0.000135, 0) (0.0002125, 0.000125, 0))
  readout_wire_Q1.sweep_along_path(readout_wire_Q1_path)
  readout_wire_sub_Q1_path = polyline(z=0, xy: (0.0002125, 0.00013) (0.0002375, 0.00013) (0.00032, 0.000195) (0.000425, 0.000195))
  readout_wire_sub_Q1 = polyline((0.0002125, 0.000141, 0) (0.0002125, 0.000119, 0))
  readout_wire_sub_Q1.sweep_along_path(readout_wire_sub_Q1_path)
  readout_wire_Q2_path = polyline(z=0, xy: (0.0007875, 0.00013) (0.0007625, 0.00013) (0.00068, 0.000195) (0.000575, 0.000195))
  readout_wire_Q2 = polyline((0.0007875, 0.000125, 0) (0.0007875, 0.000135, 0))
  readout_wire_Q2.sweep_along_path(readout_wire_Q2_path)
  readout_wire_sub_Q2_path = polyline(z=0, xy: (0.0007875, 0.00013) (0.0007625, 0.00013) (0.00068, 0.000195) (0.000575, 0.000195))
  readout_wire_sub_Q2 = polyline((0.0007875, 0.000119, 0) (0.0007875, 0.000141, 0))
  readout_wire_sub_Q2.sweep_along_path(readout_wire_sub_Q2_path)
  trace_coupler_path = polyline((0.000425, 0.000195, 0) (0.000575, 0.000195, 0))
  trace_coupler = polyline((0.000425, 0.0002, 0) (0.000425, 0.00019, 0))
  trace_coupler.sweep_along_path(trace_coupler_path)
  cut_coupler_path = polyline((0.000425, 0.000195, 0) (0.000575, 0.000195, 0))
  cut_coupler = polyline((0.000425, 0.000206, 0) (0.000425, 0.000184, 0))
  cut_coupler.sweep_along_path(cut_coupler_path)
  pad_top_Q1 = rectangle(corner=(-0.0002125, 1.5e-05, 0), x_size=0.000425, y_size=9e-05)
  pad_bot_Q1 = rectangle(corner=(-0.0002125, -0.000105, 0), x_size=0.000425, y_size=9e-05)
  rect_pk_Q1 = rectangle(corner=(-0.000325, -0.000325, 0), x_size=0.00065, y_size=0.00065)
  readout_connector_pad_Q1 = rectangle(corner=(1.25e-05, 0.00012, 0), x_size=0.0002, y_size=3e-05)
  pad_top_Q2 = rectangle(corner=(0.0007875, 1.5e-05, 0), x_size=0.000425, y_size=9e-05)
  pad_bot_Q2 = rectangle(corner=(0.0007875, -0.000105, 0), x_size=0.000425, y_size=9e-05)
  rect_pk_Q2 = rectangle(corner=(0.000675, -0.000325, 0), x_size=0.00065, y_size=0.00065)
  readout_connector_pad_Q2 = rectangle(corner=(0.0007875, 0.00012, 0), x_size=0.0002, y_size=3e-05)
  JJ_rect_Lj_Q1_rect_jj = rectangle(corner=(-1e-05, -1.5e-05, 0), x_size=2e-05, y_size=3e-05)
  JJ_Lj_Q1_rect_jj_ = polyline((0, -1.5e-05, 0) (0, 1.5e-05, 0))
  JJ_rect_Lj_Q2_rect_jj = rectangle(corner=(0.00099, -1.5e-05, 0), x_size=2e-05, y_size=3e-05)
  JJ_Lj_Q2_rect_jj_ = polyline((0.001, -1.5e-05, 0) (0.001, 1.5e-05, 0))
  ground_main_plane = rectangle(corner=(-0.000825, -0.000825, 0), x_size=0.00265, y_size=0.00165)
  main [silicon] = box(corner=(-0.000825, -0.000825, -0.00075), size=(0.00265, 0.00165, 0.00075))
  sample_holder [vacuum] = box(corner=(-0.000825, -0.000825, -0.00165), size=(0.00265, 0.00165, 0.00254))
  ground_main_plane.subtract(rect_pk_Q1, readout_wire_sub_Q1, readout_wire_sub_Q2, cut_coupler, rect_pk_Q2)
boundaries and excitations:
  Lj_Lj_Q1_rect_jj: Lumped RLC Objects=JJ_rect_Lj_Q1_rect_jj CurrentLine{(0, -0.015, 0) -> (0, 0.015, 0)} RLC_Type=Parallel Inductance=Lj1 Capacitance=Cj1
  Lj_Lj_Q2_rect_jj: Lumped RLC Objects=JJ_rect_Lj_Q2_rect_jj CurrentLine{(1, -0.015, 0) -> (1, 0.015, 0)} RLC_Type=Parallel Inductance=Lj2 Capacitance=Cj2
  PerfE: Perfect E Objects=[readout_wire_Q1, readout_wire_Q2, trace_coupler, pad_top_Q1, pad_bot_Q1, readout_connector_pad_Q1, pad_top_Q2, pad_bot_Q2, readout_connector_pad_Q2, ground_main_plane]
mesh:
  small_mesh: LengthBased Objects=[JJ_rect_Lj_Q1_rect_jj, JJ_rect_Lj_Q2_rect_jj] MaxLength=7um
setups:
  Setup: HfssEigen MinimumFrequency=1GHz NumModes=2 MaxDeltaFreq=0.05 ConvergeOnRealFreq=true MaximumPasses=15 MinimumPasses=1 MinimumConvergedPasses=1 PercentRefinement=30 BasisOrder=1
source amplitudes:
  #-10:1: 0 0
  #-10:2: 1 0
field plots:
  Mag_E1: E Field over main on Setup : LastAdaptive at Phase=0deg
reports:
  Freq. vs. pass: re(Mode(1)), re(Mode(2)) vs Pass on Setup : AdaptivePass [Cj1=0fF Cj2=0fF Lj1=13nH Lj2=9nH]
