# Ansys Electronics Desktop project, version 2025.2
materials:
  vacuum: permittivity=1
  copper: permeability=0.999991 conductivity=58000000
  silicon: permittivity=11.9
  pec: conductivity=1e+30

design SingleQubit (Q3D Extractor, model units mm)
options: SParamCalcMethod=EqTransLine Calculate_Lossy_Dielectrics
geometry:
  readout_wire_Q1_path = polyline(z=0, xy: (0.00263501, -0.0001325) (0.00266001, -0.0001325) (0.00274251, -0.0001975) (0.00284751, -0.0001975))
  readout_wire_Q1 [copper] = polyline((0.00263501, -0.000125, 0) (0.00263501, -0.00014, 0))
  readout_wire_Q1.sweep_along_path(readout_wire_Q1_path)
  readout_wire_sub_Q1_path = polyline(z=0, xy: (0.00263501, -0.0001325) (0.00266001, -0.0001325) (0.00274251, -0.0001975) (0.00284751, -0.0001975))
  readout_wire_sub_Q1 = polyline((0.00263501, -0.000116, 0) (0.00263501, -0.000149, 0))
  readout_wire_sub_Q1.sweep_along_path(readout_wire_sub_Q1_path)
  bus1_wire_Q1_path = polyline(z=0, xy: (0.00221001, 0.0001325) (0.00218501, 0.0001325) (0.00210251, 0.0001975) (0.00199751, 0.0001975))
  bus1_wire_Q1 [copper] = polyline((0.00221001, 0.000125, 0) (0.00221001, 0.00014, 0))
  bus1_wire_Q1.sweep_along_path(bus1_wire_Q1_path)
  bus1_wire_sub_Q1_path = polyline(z=0, xy: (0.00221001, 0.0001325) (0.00218501, 0.0001325) (0.00210251, 0.0001975) (0.00199751, 0.0001975))
  bus1_wire_sub_Q1 = polyline((0.00221001, 0.000116, 0) (0.00221001, 0.000149, 0))
  bus1_wire_sub_Q1.sweep_along_path(bus1_wire_sub_Q1_path)
  bus2_wire_Q1_path = polyline(z=0, xy: (0.00221001, -0.0001325) (0.00218501, -0.0001325) (0.00210251, -0.0001975) (0.00199751, -0.0001975))
  bus2_wire_Q1 [copper] = polyline((0.00221001, -0.00014, 0) (0.00221001, -0.000125, 0))
  bus2_wire_Q1.sweep_along_path(bus2_wire_Q1_path)
  bus2_wire_sub_Q1_path = polyline(z=0, xy: (0.00221001, -0.0001325) (0.00218501, -0.0001325) (0.00210251, -0.0001975) (0.00199751, -0.0001975))
  bus2_wire_sub_Q1 = polyline((0.00221001, -0.000149, 0) (0.00221001, -0.000116, 0))
  bus2_wire_sub_Q1.sweep_along_path(bus2_wire_sub_Q1_path)
  pad_top_Q1 [copper] = rectangle(corner=(0.00221001, 1.5e-05, 0), x_size=0.000425, y_size=9e-05)
  pad_bot_Q1 [copper] = rectangle(corner=(0.00221001, -0.000105, 0), x_size=0.000425, y_size=9e-05)
  rect_pk_Q1 = rectangle(corner=(0.00209751, -0.000325, 0), x_size=0.00065, y_size=0.00065)
  readout_connector_pad_Q1 [copper] = rectangle(corner=(0.00243501, -0.00015, 0), x_size=0.0002, y_size=3e-05)
  bus1_connector_pad_Q1 [copper] = rectangle(corner=(0.00221001, 0.00012, 0), x_size=0.000125, y_size=3e-05)
  bus2_connector_pad_Q1 [copper] = rectangle(corner=(0.00221001, -0.00017, 0), x_size=0.000125, y_size=5e-05)
  endcap_Q1_readout = rectangle(corner=(0.00284751, -0.000214, 0), x_size=9e-06, y_size=3.3e-05)
  endcap_Q1_bus1 = rectangle(corner=(0.00198851, 0.000181, 0), x_size=9e-06, y_size=3.3e-05)
  endcap_Q1_bus2 = rectangle(corner=(0.00198851, -0.000214, 0), x_size=9e-06, y_size=3.3e-05)
  ground_main_plane [copper] = rectangle(corner=(0.00179751, -0.000525, 0), x_size=0.00125, y_size=0.00105)
  main [silicon] = box(corner=(0.00179751, -0.000525, -0.00075), size=(0.00125, 0.00105, 0.00075))
  ground_main_plane.subtract(bus2_wire_sub_Q1, rect_pk_Q1, endcap_Q1_bus2, endcap_Q1_readout, bus1_wire_sub_Q1, readout_wire_sub_Q1, endcap_Q1_bus1)
boundaries and excitations:
  ThinCond1: ThinConductor Objects=[readout_wire_Q1, bus1_wire_Q1, bus2_wire_Q1, pad_top_Q1, pad_bot_Q1, readout_connector_pad_Q1, bus1_connector_pad_Q1, bus2_connector_pad_Q1, ground_main_plane] Material=pec Thickness=200nm
  readout_connector_pad_Q1: SignalNet Objects=[readout_wire_Q1, readout_connector_pad_Q1]
  bus1_connector_pad_Q1: SignalNet Objects=[bus1_wire_Q1, bus1_connector_pad_Q1]
  bus2_connector_pad_Q1: SignalNet Objects=[bus2_wire_Q1, bus2_connector_pad_Q1]
  pad_top_Q1: SignalNet Objects=pad_top_Q1
  pad_bot_Q1: SignalNet Objects=pad_bot_Q1
  ground_main_plane: SignalNet Objects=ground_main_plane
setups:
  Setup: Matrix AdaptiveFreq=5GHz Cap{MaxPass=6 MinPass=2 MinConvPass=2 PerError=0.5 PerRefine=30 AutoIncreaseAccuracy AccuracyLevel=Normal Solver_Type=Iterative} ErrorValue=0.1
source amplitudes:
  bus1_connector_pad_Q1, bus2_connector_pad_Q1, ground_main_plane, pad_bot_Q1, pad_top_Q1: CG Fields 0V 0deg
  readout_connector_pad_Q1: CG Fields 1V 0deg
reports:
  C Matrix Table1: C(bus1_connector_pad_Q1,bus1_connector_pad_Q1), C(bus2_connector_pad_Q1,bus1_connector_pad_Q1), C(ground_main_plane,bus1_connector_pad_Q1), C(pad_bot_Q1,bus1_connector_pad_Q1), C(pad_top_Q1,bus1_connector_pad_Q1), C(readout_connector_pad_Q1,bus1_connector_pad_Q1), C(bus1_connector_pad_Q1,bus2_connector_pad_Q1), C(bus2_connector_pad_Q1,bus2_connector_pad_Q1), C(ground_main_plane,bus2_connector_pad_Q1), C(pad_bot_Q1,bus2_connector_pad_Q1), C(pad_top_Q1,bus2_connector_pad_Q1), C(readout_connector_pad_Q1,bus2_connector_pad_Q1), C(bus1_connector_pad_Q1,ground_main_plane), C(bus2_connector_pad_Q1,ground_main_plane), C(ground_main_plane,ground_main_plane), C(pad_bot_Q1,ground_main_plane), C(pad_top_Q1,ground_main_plane), C(readout_connector_pad_Q1,ground_main_plane), C(bus1_connector_pad_Q1,pad_bot_Q1), C(bus2_connector_pad_Q1,pad_bot_Q1), C(ground_main_plane,pad_bot_Q1), C(pad_bot_Q1,pad_bot_Q1), C(pad_top_Q1,pad_bot_Q1), C(readout_connector_pad_Q1,pad_bot_Q1), C(bus1_connector_pad_Q1,pad_top_Q1), C(bus2_connector_pad_Q1,pad_top_Q1), C(ground_main_plane,pad_top_Q1), C(pad_bot_Q1,pad_top_Q1), C(pad_top_Q1,pad_top_Q1), C(readout_connector_pad_Q1,pad_top_Q1), C(bus1_connector_pad_Q1,readout_connector_pad_Q1), C(bus2_connector_pad_Q1,readout_connector_pad_Q1), C(ground_main_plane,readout_connector_pad_Q1), C(pad_bot_Q1,readout_connector_pad_Q1), C(pad_top_Q1,readout_connector_pad_Q1), C(readout_connector_pad_Q1,readout_connector_pad_Q1) vs Freq on Setup : LastAdaptive
  C Matrix: dB(C(bus1_connector_pad_Q1,bus1_connector_pad_Q1)), dB(C(bus1_connector_pad_Q1,bus2_connector_pad_Q1)), dB(C(bus1_connector_pad_Q1,ground_main_plane)), dB(C(bus1_connector_pad_Q1,pad_bot_Q1)), dB(C(bus1_connector_pad_Q1,pad_top_Q1)), dB(C(bus1_connector_pad_Q1,readout_connector_pad_Q1)), dB(C(bus2_connector_pad_Q1,bus1_connector_pad_Q1)), dB(C(bus2_connector_pad_Q1,bus2_connector_pad_Q1)), dB(C(bus2_connector_pad_Q1,ground_main_plane)), dB(C(bus2_connector_pad_Q1,pad_bot_Q1)), dB(C(bus2_connector_pad_Q1,pad_top_Q1)), dB(C(bus2_connector_pad_Q1,readout_connector_pad_Q1)), dB(C(ground_main_plane,bus1_connector_pad_Q1)), dB(C(ground_main_plane,bus2_connector_pad_Q1)), dB(C(ground_main_plane,ground_main_plane)), dB(C(ground_main_plane,pad_bot_Q1)), dB(C(ground_main_plane,pad_top_Q1)), dB(C(ground_main_plane,readout_connector_pad_Q1)), dB(C(pad_bot_Q1,bus1_connector_pad_Q1)), dB(C(pad_bot_Q1,bus2_connector_pad_Q1)), dB(C(pad_bot_Q1,ground_main_plane)), dB(C(pad_bot_Q1,pad_bot_Q1)), dB(C(pad_bot_Q1,pad_top_Q1)), dB(C(pad_bot_Q1,readout_connector_pad_Q1)), dB(C(pad_top_Q1,bus1_connector_pad_Q1)), dB(C(pad_top_Q1,bus2_connector_pad_Q1)), dB(C(pad_top_Q1,ground_main_plane)), dB(C(pad_top_Q1,pad_bot_Q1)), dB(C(pad_top_Q1,pad_top_Q1)), dB(C(pad_top_Q1,readout_connector_pad_Q1)), dB(C(readout_connector_pad_Q1,bus1_connector_pad_Q1)), dB(C(readout_connector_pad_Q1,bus2_connector_pad_Q1)), dB(C(readout_connector_pad_Q1,ground_main_plane)), dB(C(readout_connector_pad_Q1,pad_bot_Q1)), dB(C(readout_connector_pad_Q1,pad_top_Q1)), dB(C(readout_connector_pad_Q1,readout_connector_pad_Q1)) vs Pass on Setup : AdaptivePass [Freq=all]
